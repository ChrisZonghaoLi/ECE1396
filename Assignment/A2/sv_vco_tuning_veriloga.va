/*
 *  Copyright (c) 1999
 *  by Cadence Design Systems, Inc.  All rights reserved.
 *
 *  $Date: 2003/10/06 06:08:37 $
 *  $Revision: 1.1 $
 *
 *  Author:  Jess Chen
 *
 */

// Voltage controlled oscillator tuning curve.

// This model transforms input voltage into an output
// voltage representing the VCO output frequency in
// Mhz. The scale factor (sf) is there in case the
// user needs a different set of units. A change
// in those units should be reflected in the phase
// frequency detector model and reference frequency.

// frequency_out = sf*(f0 + f1*(vin-v0) + f1*(vin-v0)^2 + f2*(vin-v0)^3 + f4*(vin-v0)^4)
// in MegaHerz.

// Input voltage is in volts.

//Modified by Sorin Voinigescu to add VCO phase noise

`include "constants.h"
`include "discipline.h"

module vco_tuning_curve(frequency_out_Mhz, Vin);
output frequency_out_Mhz;
electrical frequency_out_Mhz;
input Vin;
electrical Vin;

parameter real sf = 1 from [0.0 : inf);
parameter real f0 = 34 from [0.0 : inf);
parameter real v0 = 1.5 from [0.0 : inf);
parameter real f1 = 60.0 from [0.0: inf);
parameter real f2 = 15.5;
parameter real f3 = 0.0;
parameter real f4 = 0.0;
parameter real vmax  =  20 from (v0 : inf);
parameter real vmin = 0 from [-inf : v0);

// next 4 lines added by Sorin

parameter real noise_enb = 1 from [0 : 1] ;
parameter integer pm_enb = 1 from [0 : 1] ;     // "1" for phase model and "0" for voltage model

parameter real n = 1e2 from [0:inf) ;           // white output free-running VCO phase noise at 1 Hz (rad2/Hz) -100dBc/Hz @1MHz
parameter real fc = 1e5 from [0:inf) ;          // flicker noise corner frequency (Hz) of free-running VCO in Hz

//n = 10^[(PN@1MHz+ 120)/10]

real x;
real y;
real lower;

analog begin
   if (analysis("static")) begin
      x = V(Vin) - v0;
   end
   else begin
      if ((V(Vin)>=vmin) && (V(Vin)<=vmax)) x = V(Vin)-v0;
      else if (V(Vin) < vmin) x = vmin-v0;
      else x = vmax-v0;
   end

   V(frequency_out_Mhz) <+ sf*((((f4*x+f3)*x+f2)*x+f1)*x+f0);

//next line adds the phase noise

   V(frequency_out_Mhz) <+ 1e-6 *(flicker_noise (noise_enb * n , 2 , "wpn") + flicker_noise (noise_enb * n * fc , 3 , "fpn") );

end
endmodule
